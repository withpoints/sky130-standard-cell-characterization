** sch_path: /home/rohit/projects/vlsi_phase1/xschem/tb_nand2_vtc.sch
**.subckt tb_nand2_vtc
x1 VOUT VIN VIN VDD GND NAND2
Vin VIN GND DC 0
Vdd VDD GND DC 1.8
**** begin user architecture code

.lib /usr/local/share/pdk/sky130B/libs.tech/ngspice/sky130.lib.spice tt
.option scale=1.0u
.dc Vin 0 1.8 0.005

**** end user architecture code
**.ends

* expanding   symbol:  NAND2.sym # of pins=5
** sym_path: /home/rohit/projects/vlsi_phase1/xschem/NAND2.sym
** sch_path: /home/rohit/projects/vlsi_phase1/xschem/NAND2.sch
.subckt NAND2 Y A B VPWR VGND
*.opin Y
*.ipin A
*.ipin B
*.ipin VPWR
*.ipin VGND
XM1 Y A N1 VGND sky130_fd_pr__nfet_01v8 L=0.15 W=2.0 nf=1 ad=0.58 as=0.58 pd=4.58 ps=4.58 nrd=0.145 nrs=0.145 sa=0 sb=0 sd=0
+ mult=1 m=1
XM2 N1 B VGND VGND sky130_fd_pr__nfet_01v8 L=0.15 W=2.0 nf=1 ad=0.58 as=0.58 pd=4.58 ps=4.58 nrd=0.145 nrs=0.145 sa=0 sb=0 sd=0
+ mult=1 m=1
XM3 Y A VPWR VPWR sky130_fd_pr__pfet_01v8 L=0.15 W=2.4 nf=1 ad=0.696 as=0.696 pd=5.38 ps=5.38 nrd=0.120833333333333
+ nrs=0.120833333333333 sa=0 sb=0 sd=0 mult=1 m=1
XM4 Y B VPWR VPWR sky130_fd_pr__pfet_01v8 L=0.15 W=2.4 nf=1 ad=0.696 as=0.696 pd=5.38 ps=5.38 nrd=0.120833333333333
+ nrs=0.120833333333333 sa=0 sb=0 sd=0 mult=1 m=1
.ends

.GLOBAL GND
**** begin user architecture code

.control
run
meas dc vm FIND v(VIN) WHEN v(VOUT)=0.9
wrdata nand2_vtc.csv v(VIN) v(VOUT)
print vm
.endc

**** end user architecture code
.end
