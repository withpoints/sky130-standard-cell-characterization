** sch_path: /home/rohit/projects/vlsi_phase1/xschem/tb_inv_vtc.sch
**.subckt tb_inv_vtc
x1 VOUT VIN VDD GND INV
Vin VIN GND DC 0
Vdd VDD GND DC 1.8
**** begin user architecture code

.lib /usr/local/share/pdk/sky130B/libs.tech/ngspice/sky130.lib.spice tt
.option scale=1.0u
.dc Vin 0 1.8 0.005

**** end user architecture code
**.ends

* expanding   symbol:  INV.sym # of pins=4
** sym_path: /home/rohit/projects/vlsi_phase1/xschem/INV.sym
** sch_path: /home/rohit/projects/vlsi_phase1/xschem/INV.sch
.subckt INV Y A VPWR VGND
*.opin Y
*.ipin A
*.ipin VPWR
*.ipin VGND
XM1 Y A VGND VGND sky130_fd_pr__nfet_01v8 L=0.15 W=1.0 nf=1 ad=0.29 as=0.29 pd=2.58 ps=2.58 nrd=0.29 nrs=0.29 sa=0 sb=0 sd=0
+ mult=1 m=1
XM2 Y A VPWR VPWR sky130_fd_pr__pfet_01v8 L=0.15 W=2.5 nf=1 ad=0.725 as=0.725 pd=5.58 ps=5.58 nrd=0.116 nrs=0.116 sa=0 sb=0 sd=0
+ mult=1 m=1
.ends

.GLOBAL GND
**** begin user architecture code

.control
run
meas dc vm FIND v(VIN) WHEN v(VOUT)=0.9
wrdata inv_vtc.csv v(VIN) v(VOUT)
print vm
.endc

**** end user architecture code
.end
