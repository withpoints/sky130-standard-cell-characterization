** sch_path: /home/rohit/projects/vlsi_phase1/xschem/tb_inv_tran.sch
**.subckt tb_inv_tran
x1 VOUT VIN VDD GND INV
Vin VIN GND PULSE(0 1.8 1n 100p 100p 5n 10n)
Vdd VDD GND DC 1.8
Cload VOUT GND 10f m=1
**** begin user architecture code

.lib /usr/local/share/pdk/sky130B/libs.tech/ngspice/sky130.lib.spice tt
.option scale=1.0u
.tran 10p 20n

**** end user architecture code
**.ends

* expanding   symbol:  INV.sym # of pins=4
** sym_path: /home/rohit/projects/vlsi_phase1/xschem/INV.sym
** sch_path: /home/rohit/projects/vlsi_phase1/xschem/INV.sch
.subckt INV Y A VPWR VGND
*.opin Y
*.ipin A
*.ipin VPWR
*.ipin VGND
XM1 Y A VGND VGND sky130_fd_pr__nfet_01v8 L=0.15 W=0.42 nf=1 ad=0.1218 as=0.1218 pd=1.42 ps=1.42 nrd=0.69047619047619
+ nrs=0.69047619047619 sa=0 sb=0 sd=0 mult=1 m=1
XM2 Y A VPWR VPWR sky130_fd_pr__pfet_01v8 L=0.15 W=1.26 nf=1 ad=0.3654 as=0.3654 pd=3.1 ps=3.1 nrd=0.23015873015873
+ nrs=0.23015873015873 sa=0 sb=0 sd=0 mult=1 m=1
.ends

.GLOBAL GND
**** begin user architecture code

.control
run
meas tran tpHL trig v(VIN) val=0.9 rise=1 targ v(VOUT) val=0.9 fall=1
meas tran tpLH trig v(VIN) val=0.9 fall=1 targ v(VOUT) val=0.9 rise=1
meas tran tf_out trig v(VOUT) val=1.62 fall=1 targ v(VOUT) val=0.18 fall=1
meas tran tr_out trig v(VOUT) val=0.18 rise=1 targ v(VOUT) val=1.62 rise=1
wrdata inv_tran.csv v(VIN) v(VOUT)
.endc

**** end user architecture code
.end
