* SPICE3 file created from /home/rohit/projects/vlsi_phase3/spice/inverter.ext - technology: sky130A

X0 Out G VSS VSS sky130_fd_pr__nfet_01v8 ad=0.1848 pd=1.72 as=0.1848 ps=1.72 w=0.42 l=0.15
X1 Out G VDD VDD sky130_fd_pr__pfet_01v8 ad=0.567 pd=3.42 as=0.5544 ps=3.4 w=1.26 l=0.15
C0 Out G 0.03815f
C1 VDD G 0.14233f
C2 Out VDD 0.16696f
C3 Out VSS 0.21534f
C4 G VSS 0.31531f
C5 VDD VSS 0.7084f
